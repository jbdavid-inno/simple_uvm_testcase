// AMS netlist generated by the AMS Unified netlister
// IC subversion:  ICADVM20.1-64b.500.32
// Xcelium version: 23.03-s002
// Copyright(C) 2005-2009, Cadence Design Systems, Inc
// User: jdavid Pid: 122492
// Design library name: RFDV_scratch
// Design cell name: simple_uvm_testcase
// Design view name: config_uvm
// Solver: Spectre

// HDL file - RFDV_scratch, bused_port_bias_gen, MiM_DE.
// HDL file - RFDV_scratch, clk_dist_block, MiM_DE.
`include "disciplines.vams"
`include "userDisciplines.vams"
// HDL file - RFDV_scratch, bused_port_bias_gen, MiM_DE.
// HDL file - RFDV_scratch, clk_dist_block, MiM_DE.
// Library - RFDV_scratch, Cell - simple_uvm_testcase, View - schematic
// LAST TIME SAVED: Nov  6 09:46:13 2023
// NETLIST TIME: Dec  8 13:28:03 2023
`timescale 1ns / 1ns

`worklib RFDV_scratch
`view schematic

(* cds_ams_schematic *)

module simple_uvm_testcase (clk_out_0, clk_out_1, clk_out_2, clk_out_3,
    dll_lock_status, vcntrl0, vcntrl1, vcntrl2, vcntrl3, AVDD1P8, AVSS,
    bg_enable, clk_en, mclk_in, mode_sel_0, mode_sel_1, mode_sel_2,
    mode_sel_3);

output  clk_out_0, clk_out_1, clk_out_2, clk_out_3, vcntrl0, vcntrl1,
    vcntrl2, vcntrl3;

input  AVDD1P8, AVSS, bg_enable, mclk_in;

output [3:0]  dll_lock_status;

input [1:0]  mode_sel_3;
input [3:0]  clk_en;
input [1:0]  mode_sel_1;
input [1:0]  mode_sel_2;
input [1:0]  mode_sel_0;

// Buses in the design

wire  [3:0]  Ipt_10u;

bused_port_bias_gen B_mainbias ( .Ipt_10u(Ipt_10u), .AVDD1P8(AVDD1P8),
    .AVSS(AVSS), .bg_enable(bg_enable));

clk_dist_block A_clkbuf_3 ( .Ibg_10u(Ipt_10u_3), .clk_out(clk_out_3),
    .dll_locked(dll_lock_status[3]), .vcntrl(vcntrl3),
    .AVDD_1P8(AVDD1P8), .AVSS(AVSS), .clk_en(clk_en[3]),
    .mclk_in(mclk_in), .mode_sel(mode_sel_3));

clk_dist_block A_clkbuf_2 ( .Ibg_10u(Ipt_10u_2), .clk_out(clk_out_2),
    .dll_locked(dll_lock_status[2]), .vcntrl(vcntrl2),
    .AVDD_1P8(AVDD1P8), .AVSS(AVSS), .clk_en(clk_en[2]),
    .mclk_in(mclk_in), .mode_sel(mode_sel_2));

clk_dist_block A_clkbuf_1 ( .Ibg_10u(Ipt_10u_1), .clk_out(clk_out_1),
    .dll_locked(dll_lock_status[1]), .vcntrl(vcntrl1),
    .AVDD_1P8(AVDD1P8), .AVSS(AVSS), .clk_en(clk_en[1]),
    .mclk_in(mclk_in), .mode_sel(mode_sel_1));

clk_dist_block A_clkbuf_0 ( .Ibg_10u(Ipt_10u_0), .clk_out(clk_out_0),
    .dll_locked(dll_lock_status[0]), .vcntrl(vcntrl0),
    .AVDD_1P8(AVDD1P8), .AVSS(AVSS), .clk_en(clk_en[0]),
    .mclk_in(mclk_in), .mode_sel(mode_sel_0));

presistor  R1_3 ( .MINUS(Ipt_10u_3), .PLUS(Ipt_10u[3]));

presistor  R1_2 ( .MINUS(Ipt_10u_2), .PLUS(Ipt_10u[2]));

presistor  R1_1 ( .MINUS(Ipt_10u_1), .PLUS(Ipt_10u[1]));

presistor  R1_0 ( .MINUS(Ipt_10u_0), .PLUS(Ipt_10u[0]));

endmodule
`noworklib
`noview

 // END AMS-UNL Netlist
