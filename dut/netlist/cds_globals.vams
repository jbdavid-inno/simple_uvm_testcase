// Verilog-AMS cds_globals module for top-level cell:
//    RFDV_scratch/simple_uvm_testcase.
// Generated by ADE.
// Cadence Design Systems, Inc.

// This is an autoGenerated file, any changes done to this file may get lost.

`include "disciplines.vams"
`include "userDisciplines.vams"

module cds_globals;

// Global Signals

// Design Variables
   dynamicparam real temperature = 27;
   dynamicparam real wireopt = 19;

endmodule
