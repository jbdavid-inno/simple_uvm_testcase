// This is the Cadence AMS Designer(R) analog simulation control file.
// It specifies the options and analyses for the Spectre analog solver.

simulator lang=spectre

global 0

simulatorOptions options psfversion="1.4.0" temp=27 tnom=27 scale=1.0 \
scalem=1.0 reltol=1e-3 vabstol=1e-6 iabstol=1e-12 gmin=1e-12 rforce=1 \
maxnotes=5 maxwarns=5 digits=5 pivrel=1e-3 checklimitdest=psf

tran tran stop=1 write="spectre.ic" writefinal="spectre.fc" \
annotate=status maxiters=5

finalTimeOP info what=oppoint where=rawfile

saveAhdlOptions options saveahdlvars=selected
